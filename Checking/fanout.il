procedure(fanout(@optional (SmdOnly nil))
let((NetPinCnt PinCnt PinList ViaList)
logfile = "fanout.log"
originalVisible=axlVisibleGet()
designName = axlCurrentDesign()
design_path = axlGetDrawingName()
design_unit = car(axlDBGetDesignUnits())
axlVisibleDesign(t)
timeperform = fileTimeModified("fanout.log")
port = axlDMOpenLog(logfile)
fprintf(port, "Design name: %s\n", design_path)
fprintf(port, "%s\n", "------------------------------------------------")
fprintf(port, "%-18s %-18s  \n\n", "PIN", "XY Location")
(PinCnt=0)
if(SmdOnly then
axlMsgPut("SMD only")
else
axlMsgPut("all pins")
)
foreach(net (axlDBGetDesign)->nets
when(net->unconnected>0
(NetPinCnt = 0)
foreach(branch (net->branches)
(PinList = setof(c (branch->children) ((c->objType) == "pin")))
(ViaList = setof(c (branch->children) ((c->objType) == "via")))
(NetPinCnt = NetPinCnt + length(PinList))
when(eq(0 length(ViaList))
if(SmdOnly then
(ViaList = setof(c PinList ((c->isThrough) == t)))
when(eq(0 length(ViaList))
foreach(pinlp PinList
	refval = sprintf(nil "%s%s%s",pinlp->parent->refdes, ".", pinlp->number)
	fprintf(port, "%-18s %-18L\n", refval, pinlp ->xy)
)
axlHighlightObject(PinList t)
(PinCnt=PinCnt+length(PinList))
)
else
(ViaList = setof(c PinList ((c->isThrough) == t)))
when(eq(0 length(ViaList))
foreach(pinlp PinList
	refval = sprintf(nil "%s%s%s",pinlp->parent->refdes, ".", pinlp->number)
	fprintf(port, "%-18s %-18L\n", refval, pinlp ->xy)
)
axlHighlightObject(PinList t)
(PinCnt=PinCnt+length(PinList))
)
)
)
)
when(and(eq(1 NetPinCnt) SmdOnly)
axlDehighlightObject(PinList t)
PinCnt--
)
)
)
axlDMClose(port)
axlVisibleSet(originalVisible)
axlUIViewFileCreate(logfile, "Fanout", nil, '(30 25), '(CENTER))
axlMsgPut("%d Pins Highlighted" PinCnt)
)
)
axlCmdRegister("fanout" 'fanout)
