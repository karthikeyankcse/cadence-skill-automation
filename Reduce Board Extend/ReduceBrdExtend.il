axlCmdRegister("ReduceBrdExtend" 'ReduceBrdExtend)
procedure(ReduceBrdExtend()
originalVisible = axlVisibleGet()
axlVisibleDesign(nil)
axlVisibleLayer(strcat("MANUFACTURING/", "PHOTOPLOT_OUTLINE") t)
axlVisibleUpdate(t)
axlClearSelSet()
axlSetFindFilter(?enabled `("NOALL" "SHAPES") ?onButtons `("SHAPES"))
PhotoPlotDtLst = axlGetSelSet(axlAddSelectAll())
PhotoPlotDt = car(PhotoPlotDtLst)
StartXYPoint = car(PhotoPlotDt->bBox)
EndXYPoint = cadr(PhotoPlotDt->bBox)
StartXPoint = car(StartXYPoint)
StartYPoint = cadr(StartXYPoint)
EndXPoint = car(EndXYPoint)
EndYPoint = cadr(EndXYPoint)
if(PhotoPlotDtLst != nil then
axlVisibleDesign(t)
axlClearSelSet()
axlSetFindFilter(?enabled `("NOALL" "LINES" "TEXT" "SHAPES") ?onButtons `("LINES" "TEXT" "SHAPES"))
SelDataAll = axlGetSelSet(axlAddSelectAll())
axlClearSelSet()
axlSetFindFilter(?enabled `("NOALL" "LINES" "TEXT" "SHAPES") ?onButtons `("LINES" "TEXT" "SHAPES"))
SelDataReg = axlGetSelSet(axlSingleSelectBox( list(StartXPoint:StartYPoint EndXPoint:EndYPoint)))
SelDataRegUp = append(PhotoPlotDtLst SelDataReg)
DelObj = setof(item, SelDataAll, !member(item, SelDataRegUp))
DelObjLen = length(DelObj)
Val = sprintf(nil "Total No of Object Deleted - %d", DelObjLen)
println(Val)
foreach(DelObjlp DelObj
	axlDeleteObject(DelObjlp)
)
if(DelObj != nil then
	axlUIConfirm("OutSide Selected Boundary Objects Deleted Successfully...!")
else
	axlUIConfirm("No Objects found to Delete...!")
)
else
	axlUIConfirm("Error: No Photoplot Line Found...!")
)
axlVisibleSet(originalVisible)
axlClearSelSet()
)
